* v3: add L298 enable propagation delay (~3us) between ENA pin and bridge switches
* variant: Rs 0.33 ohm + NPN limiter
V12 vin 0 DC 12
Rin vin vs 0.05
Cbulk vs 0 1000u
VPWM pwm 0 PULSE(0 5 0 10n 10n 0.796m 1.0204m)
Rg pwm ena 1k
Cena ena 0 20p
Rd ena ctl 1k
Cd ctl 0 2n
S1 vs a ctl 0 SWM
S2 n2 ns ctl 0 SWS
.model SWM SW(Vt=2.3 Vh=0.2 Ron=1.10 Roff=1Meg)
.model SWS SW(Vt=2.3 Vh=0.2 Ron=0.05 Roff=1Meg)
Vdrop a n1 DC 1.4
Vm n1 n1b DC 0
L1 n1b nl 2m
Rm nl n2 2.2
Rs ns 0 0.33
D1 0 n1 DMOD
D2 n2 vs DMOD
.model DMOD D(IS=1e-9 N=1.2 RS=0.05 CJO=50p TT=10n)
Q1 ena bq 0 QN
Rb ns bq 1k
.model QN NPN(IS=1e-14 BF=200 CJE=5p CJC=3p TF=0.4n TR=50n)
.control
tran 0.05u 12m 0 0.1u
meas tran ipk MAX i(Vm) from=5m to=12m
meas tran iavg AVG i(Vm) from=5m to=12m
meas tran vsmax MAX v(ns) from=5m to=12m
meas tran vsmin MIN v(ns) from=5m to=12m
quit
.endc
.end
